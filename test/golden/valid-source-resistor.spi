* Generated by Interactive Circuit Maker netlist-export/1.0

.subckt TopCell
R1 VIN 0 1k
V1 VIN 0 DC 5
.ends TopCell
