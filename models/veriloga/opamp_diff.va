// Behavioral DIFF opamp (diff-in / diff-out) for OpenVAF → OSDI / ngspice
// Pins: inp inm outp outm vdd vss
`include "disciplines.vams"

module opamp_diff(inp, inm, outp, outm, vdd, vss);
    inout inp, inm, outp, outm, vdd, vss;
    electrical inp, inm, outp, outm, vdd, vss;
    electrical vod_raw, vod_f, outpi, outmi;

    parameter real av0   = 10.0e3 from (0:inf);
    parameter real gbw   = 1.0e6  from (0:inf);
    parameter real rin   = 100.0e6 from (0:inf);
    parameter real rout  = 10.0e3 from (0:inf);
    parameter real vos   = 1.0e-3;
    parameter real acm   = 10.0   from [0:inf);
    parameter real vocm  = 0.9;
    parameter real swing = 0.9    from (0:inf);

    localparam real PI    = 3.141592653589793;
    localparam real fp    = gbw / av0;
    localparam real rpole = 1.0e3;
    localparam real cpole = 1.0 / (2.0 * PI * fp * rpole);

    real vic;

    analog begin
        I(inp, inm) <+ V(inp, inm) / rin;
        vic = 0.5 * (V(inp) + V(inm));
        V(vod_raw) <+ (2.0 * swing) * tanh(av0 * (V(inp, inm) - vos) / (2.0 * swing + 1.0e-12));
        I(vod_raw, vod_f) <+ V(vod_raw, vod_f) / rpole;
        I(vod_f) <+ cpole * ddt(V(vod_f));
        V(outpi) <+ vocm + 0.5 * V(vod_f) + acm * (vic - vocm);
        V(outmi) <+ vocm - 0.5 * V(vod_f) + acm * (vic - vocm);
        V(outp, outpi) <+ I(outp, outpi) * rout;
        V(outm, outmi) <+ I(outm, outmi) * rout;
    end
endmodule
